* PM28 bench 'bucks': both rails: 25 -> 100 % load steps in 1 us, then 16 -> 38 V line ramps at full load
* Generated by sim/run.py from calc/sizing.json. Edit there, not here.
.include models.lib
.lib LTC4364-2.sub
.lib LT8641.sub
.lib LTC3.lib
.lib standard.mos
.lib standard.dio
VB VBUS 0 PWL(0 28 3.8m 28 4.0m 16 4.2m 16 4.6m 38 4.8m 38 5.0m 28)
VEN ENOUT 0 PWL(0 0 50u 5)
* ---- 5V0 buck (LT8641, 1 MHz, FCM + spread spectrum)
XU5 V5 INT5 BST5 VBUS NC5a 0 NC5b SW5 NC5c 0 NC5d NC5e VBUS ENOUT RT5 SS5 INT5 0 PG5 FB5 LT8641
CIA5 VBUS 0 1e-06 Rser=5m
CIB5 VBUS 0 1e-06 Rser=5m
CIC5 VBUS 0 4.7e-06 Rser=5m
CBST5 BST5 SW5 0.1u
CINT5 INT5 0 1u
RRT5 RT5 0 41200
CSS5 SS5 0 4.7e-09
L5 SW5 V5 4.7u Rser=37m
CO5A V5 0 1.3e-05 Rser=3m
CO5B V5 0 1.3e-05 Rser=3m
* ^ 22 uF 10 V X7R 1210, modelled at its capacitance under DC bias
RFT5 V5 FB5 777000
RFB5 FB5 0 150000
CFF5 V5 FB5 2.2e-11
RPG5 PG5 V3 100k
* ---- 3V3 buck (LT8641, 1 MHz, FCM + spread spectrum)
XU3 V3 INT3 BST3 VBUS NC3a 0 NC3b SW3 NC3c 0 NC3d NC3e VBUS ENOUT RT3 SS3 INT3 0 PG3 FB3 LT8641
CIA3 VBUS 0 1e-06 Rser=5m
CIB3 VBUS 0 1e-06 Rser=5m
CIC3 VBUS 0 4.7e-06 Rser=5m
CBST3 BST3 SW3 0.1u
CINT3 INT3 0 1u
RRT3 RT3 0 41200
CSS3 SS3 0 4.7e-09
L3 SW3 V3 4.7u Rser=37m
CO3A V3 0 1.5e-05 Rser=3m
CO3B V3 0 1.5e-05 Rser=3m
* ^ 22 uF 10 V X7R 1210, modelled at its capacitance under DC bias
RFT3 V3 FB3 505000
RFB3 FB3 0 164000
CFF3 V3 FB3 2.2e-11
RPG3 PG3 V3 100k
VSTEP STEP 0 PWL(0 0 3m 0 3.001m 1 3.5m 1 3.501m 0 3.7m 0 3.701m 1)
RL5 V5 0 R=1/(0.10000+0.30000*V(STEP))
RL3 V3 0 R=1/(0.07576+0.22727*V(STEP))
.tran 0 5.2m 0 20n
.save V(VBUS) V(V5) V(V3) I(L5) I(L3) I(RL5) I(RL3)
.end
