* PM28 bench 'pulse2a': ISO 7637-2 pulse 2a (+112 V on 28 V, 2 ohm, 50 us) at full load
* Generated by sim/run.py from calc/sizing.json. Edit there, not here.
.include models.lib
.lib LTC4364-2.sub
.lib LT8641.sub
.lib LTC3.lib
.lib standard.mos
.lib standard.dio
BVS SRCV 0 V=28*min(max((time-1m)/100u,0),1) + if(time<10m,0,if(time<10m+1u,112*(time-10m)/1u,112*exp(-(time-10m-1u)/21.7u)))
RSRC SRCV IN 2
* ---- front end: PTC, TVS, LTC4364-2 surge stopper + ideal diode, breaker
RF1 IN NF 0.1
* ^ MF-RX250/72 cold resistance. Its trip is thermal (seconds) and isn't modelled.
XD1 NF 0 SMCJ58CA
M1 NF HG SRC SRC IPB072N15N3
M2 SNS DG SRC SRC BSC060N10NS3
RSNS SNS VBUS 0.02
RHG HG HGP 10
CHG HGP 0 2.2e-09
D2 NF VD BAS21HY
RUV1 VD UV 1.05e+06
RUV2 UV 0 100000
RVCC VD VCC 1000
CVCC VCC 0 1e-07
DZ1 0 VCC MMSZ5265B
RFB1 VBUS FB 147000
RFB2 FB 0 4990
CTMR TMR 0 6.8e-06
XU1 VBUS SNS DG SRC HGP VCC VCC UV 0 0 FLT ENOUT TMR FB LTC4364-2
RFLT FLT V3 100k
RENO ENOUT VBUS 100k
CBUS VBUS 0 4.7e-05 Rser=0.3
* ---- 5V0 buck (LT8641, 1 MHz, FCM + spread spectrum)
XU5 V5 INT5 BST5 VBUS NC5a 0 NC5b SW5 NC5c 0 NC5d NC5e VBUS ENOUT RT5 SS5 INT5 0 PG5 FB5 LT8641
CIA5 VBUS 0 1e-06 Rser=5m
CIB5 VBUS 0 1e-06 Rser=5m
CIC5 VBUS 0 4.7e-06 Rser=5m
CBST5 BST5 SW5 0.1u
CINT5 INT5 0 1u
RRT5 RT5 0 41200
CSS5 SS5 0 4.7e-09
L5 SW5 V5 4.7u Rser=37m
CO5A V5 0 1.3e-05 Rser=3m
CO5B V5 0 1.3e-05 Rser=3m
* ^ 22 uF 10 V X7R 1210, modelled at its capacitance under DC bias
RFT5 V5 FB5 777000
RFB5 FB5 0 150000
CFF5 V5 FB5 2.2e-11
RPG5 PG5 V3 100k
* ---- 3V3 buck (LT8641, 1 MHz, FCM + spread spectrum)
XU3 V3 INT3 BST3 VBUS NC3a 0 NC3b SW3 NC3c 0 NC3d NC3e VBUS ENOUT RT3 SS3 INT3 0 PG3 FB3 LT8641
CIA3 VBUS 0 1e-06 Rser=5m
CIB3 VBUS 0 1e-06 Rser=5m
CIC3 VBUS 0 4.7e-06 Rser=5m
CBST3 BST3 SW3 0.1u
CINT3 INT3 0 1u
RRT3 RT3 0 41200
CSS3 SS3 0 4.7e-09
L3 SW3 V3 4.7u Rser=37m
CO3A V3 0 1.5e-05 Rser=3m
CO3B V3 0 1.5e-05 Rser=3m
* ^ 22 uF 10 V X7R 1210, modelled at its capacitance under DC bias
RFT3 V3 FB3 505000
RFB3 FB3 0 164000
CFF3 V3 FB3 2.2e-11
RPG3 PG3 V3 100k
RL5 V5 0 2.5
RL3 V3 0 3.3
.tran 0 10.6m 0 20n
.save V(IN) V(NF) V(SRC) V(VBUS) V(TMR) V(FLT) V(ENOUT) V(HGP) V(VCC) I(RF1) I(RSNS) Id(M1) Id(M2) V(SNS) V(V5) V(V3) Ix(XD1:A)
.end
