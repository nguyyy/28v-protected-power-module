* PM28 bench 'loaddump': ISO 16750-2 suppressed load dump, 58 V / 1 ohm / 400 ms flat top
* Generated by sim/run.py from calc/sizing.json. Edit there, not here.
.include models.lib
.lib LTC4364-2.sub
.lib LT8641.sub
.lib LTC3.lib
.lib standard.mos
.lib standard.dio
VS SRCV 0 PWL(0 0 1m 28 50m 28 55m 58 455m 58 465m 28)
RSRC SRCV IN 1
* ---- front end: PTC, TVS, LTC4364-2 surge stopper + ideal diode, breaker
RF1 IN NF 0.1
* ^ MF-RX250/72 cold resistance. Its trip is thermal (seconds) and isn't modelled.
XD1 NF 0 SMCJ58CA
M1 NF HG SRC SRC IPB072N15N3
M2 SNS DG SRC SRC BSC060N10NS3
RSNS SNS VBUS 0.02
RHG HG HGP 10
CHG HGP 0 2.2e-09
D2 NF VD BAS21HY
RUV1 VD UV 1.05e+06
RUV2 UV 0 100000
RVCC VD VCC 1000
CVCC VCC 0 1e-07
DZ1 0 VCC MMSZ5265B
RFB1 VBUS FB 147000
RFB2 FB 0 4990
CTMR TMR 0 6.8e-06
XU1 VBUS SNS DG SRC HGP VCC VCC UV 0 0 FLT ENOUT TMR FB LTC4364-2
RFLT FLT V3 100k
RENO ENOUT VBUS 100k
CBUS VBUS 0 4.7e-05 Rser=0.3
V3 V3 0 3.3
BLD VBUS 0 I=if(V(ENOUT)>2, 15.647/max(V(VBUS),16)*min(1,V(VBUS)/16), 0)
* ^ constant-power stand-in for both bucks (13.3 W out at 85 %), enabled by ENOUT
.tran 0 600m 0 50u
.save V(IN) V(NF) V(SRC) V(VBUS) V(TMR) V(FLT) V(ENOUT) V(HGP) V(VCC) I(RF1) I(RSNS) Id(M1) Id(M2) V(SNS)
.end
